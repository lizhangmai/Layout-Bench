** sch_path: /source/FMD_QNC_03a_TIA_1.sch
.subckt FMD_QNC_03a_TIA_1 INPUT OUTPUT VCC2V VCC2V1 VEE
*.PININFO INPUT:B OUTPUT:B VCC2V:B VCC2V1:B VEE:B
QQ1 DN1 INPUT VEE VEE npn13G2 le=900e-9 we=70.0n Nx=5
QQ2 OUTPUT DN1 VEE VEE npn13G2 le=900e-9 we=70.0n Nx=4
RRC1 VCC2V DN1 VEE rppd w=15u l=4u b=0 m=1
RRC2 VCC2V1 OUTPUT VEE rppd w=11.5u l=2u b=0 m=1
RRF DN1 INPUT VEE rppd w=29u l=6.3u b=0 m=1
CC1 VCC2V VEE cap_cmim w=30u l=30u m=1
CC2 VCC2V1 VEE cap_cmim w=30u l=30u m=1
RRTAP VEE VEE ptap1 A=3.6504e-12 P=18.72e-6
.ends
