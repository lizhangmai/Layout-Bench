** sch_path: /source/DIFF_COMPARATOR.sch
.subckt DIFF_COMPARATOR vdd gnd v+ v- clk out- out+ vbias
*.PININFO vdd:B gnd:B v+:I v-:I clk:I out-:O out+:O vbias:I
MM2 net3 v+ net1 well sg13_lv_pmos w=8u l=200n ng=2 m=4
MM1 net2 v- net1 well sg13_lv_pmos w=8u l=200n ng=2 m=4
MM4 out- net2 vdd well sg13_lv_pmos w=8u l=0.200u ng=2 m=1
MM5 out+ net3 vdd well sg13_lv_pmos w=8u l=0.200u ng=2 m=1
MM11 gnd net3 out+ sub sg13_lv_nmos w=4.0u l=0.200u ng=2 m=1
MM12 gnd net2 out- sub sg13_lv_nmos w=4.0u l=0.200u ng=2 m=1
MM6 gnd net2 net3 sub sg13_lv_nmos w=4.0u l=0.200u ng=1 m=1
MM10 gnd clk net3 sub sg13_lv_nmos w=4.0u l=0.200u ng=1 m=1
MM7 gnd clk net2 sub sg13_lv_nmos w=4.0u l=0.200u ng=1 m=1
MM8 gnd net3 net2 sub sg13_lv_nmos w=4.0u l=0.200u ng=1 m=1
?
MM3 gnd gnd gnd sub sg13_lv_nmos w=4.0u l=0.200u ng=1 m=4
?
MM13 net1 clk net4 well sg13_lv_pmos w=18u l=0.3u ng=4 m=1
MM9 net4 vbias vdd well sg13_lv_pmos w=18u l=0.3u ng=4 m=1
.ends
.end
