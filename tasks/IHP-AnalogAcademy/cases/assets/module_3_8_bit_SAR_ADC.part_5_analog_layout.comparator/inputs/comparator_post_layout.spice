* Candidate-aware adapter of the pinned upstream comparator_tb.sch.
* The supplies, clocks, input ramp, load capacitors, and 1 us transient are
* copied from the upstream deck.  The DUT is supplied by post-layout extraction.
.include dut.spice
.lib cornerMOSlv.lib mos_tt
.param clock=100e6
.param period={1/clock}
.param num_cycles=100
.param tr={num_cycles*period}
VDD VDD 0 DC 1.2
VBIAS VBIAS 0 DC 0.6
VCLK CLK 0 PULSE(0 1.2 0 0 0 5N {period})
VINP VINP 0 PULSE(595e-3 605e-3 0 {tr} 1S 1S)
CINP VINP 0 6.4p
CBIAS VBIAS 0 6.4p
COUTP OUTP 0 50f
COUTM OUTM 0 50f
XDUT VDD 0 VINP 0 CLK OUTM OUTP VBIAS DIFF_COMPARATOR
.tran 500p 1u
.measure tran differential_peak MAX par('abs(v(OUTP)-v(OUTM))') FROM=0 TO=1u
.measure tran differential_final FIND par('v(OUTP)-v(OUTM)') AT=1u
.end
