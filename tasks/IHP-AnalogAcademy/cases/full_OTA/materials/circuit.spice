** sch_path: /workspace/source/two_stage_OTA_layout.sch
.subckt two_stage_OTA_layout v- v+ vss vdd iout vout
*.PININFO v-:B v+:B vss:B vdd:B iout:B vout:B
XM4 dn4 dn3 vss bulk2 sg13_lv_nmos w=720n l=9.75u ng=1 m=1 mm_ok=1
XM3 dn3 dn3 vss bulk2 sg13_lv_nmos w=720n l=9.75u ng=1 m=1 mm_ok=1
XM1 dn3 v- dn2 bulk sg13_lv_pmos w=3.64u l=3.7u ng=1 m=2 mm_ok=1
XM2 dn4 v+ dn2 bulk sg13_lv_pmos w=3.64u l=3.7u ng=1 m=2 mm_ok=1
XM7 dn2 iout vdd bulk1 sg13_lv_pmos w=5.3u l=1.95u ng=1 m=1 mm_ok=1
XM5 vout iout vdd bulk4 sg13_lv_pmos w=75u l=2.08u ng=8 m=1 mm_ok=1
XM6 vout dn4 vss bulk2 sg13_lv_nmos w=28.8u l=9.75u ng=4 m=1 mm_ok=1
XM9 iout iout vdd bulk4 sg13_lv_pmos w=75u l=2.08u ng=8 m=1 mm_ok=1
XC2 dn4 vout cap_cmim w=22.295e-6 l=22.295e-6 m=1 mm_ok=1
XM8 dn4 vdd vdd bulk sg13_lv_pmos w=3.64u l=3.7u ng=1 m=2 mm_ok=1
XM10 dn3 vdd vdd bulk sg13_lv_pmos w=3.64u l=3.7u ng=1 m=2 mm_ok=1
XM15 dn2 vdd vdd bulk sg13_lv_pmos w=3.64u l=3.7u ng=1 m=2 mm_ok=1
XM16 dn2 vdd vdd bulk sg13_lv_pmos w=3.64u l=3.7u ng=1 m=2 mm_ok=1
XR1 vdd bulk ntap1 a=28.1356e-12 p=181.52e-6 r=4.674333
XR3 vdd bulk1 ntap1 a=6.9626e-12 p=44.92e-6 r=18.8888
XR5 vdd bulk4 ntap1 a=26.815e-12 p=173e-6 r=4.904537
XR2 vss bulk2 ptap1 a=8.559e-12 p=57.06e-6 r=14.9347
XR4 vss bulk2 ptap1 a=30.288e-12 p=201.92e-6 r=4.220354
.ends
