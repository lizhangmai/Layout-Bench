** sch_path: /source/two_stage_OTA_layout.sch
.subckt two_stage_OTA_layout v- v+ vss vdd iout vout
*.PININFO v-:B v+:B vss:B vdd:B iout:B vout:B
MM4 dn4 dn3 vss bulk2 sg13_lv_nmos w=720n l=9.75u ng=1 m=1
MM3 dn3 dn3 vss bulk2 sg13_lv_nmos w=720n l=9.75u ng=1 m=1
MM1 dn3 v- dn2 bulk sg13_lv_pmos w=3.64u l=3.7u ng=1 m=2
MM2 dn4 v+ dn2 bulk sg13_lv_pmos w=3.64u l=3.7u ng=1 m=2
MM7 dn2 iout vdd bulk1 sg13_lv_pmos w=5.3u l=1.95u ng=1 m=1
MM5 vout iout vdd bulk4 sg13_lv_pmos w=75u l=2.08u ng=8 m=1
MM6 vout dn4 vss bulk2 sg13_lv_nmos w=28.8u l=9.75u ng=4 m=1
MM9 iout iout vdd bulk4 sg13_lv_pmos w=75u l=2.08u ng=8 m=1
CC2 dn4 vout cap_cmim w=22.295e-6 l=22.295e-6 m=1
MM8 dn4 vdd vdd bulk sg13_lv_pmos w=3.64u l=3.7u ng=1 m=2
MM10 dn3 vdd vdd bulk sg13_lv_pmos w=3.64u l=3.7u ng=1 m=2
MM15 dn2 vdd vdd bulk sg13_lv_pmos w=3.64u l=3.7u ng=1 m=2
MM16 dn2 vdd vdd bulk sg13_lv_pmos w=3.64u l=3.7u ng=1 m=2
RR1 vdd bulk ntap1 A=28.1356e-12 P=181.52e-6
RR3 vdd bulk1 ntap1 A=6.9626e-12 P=44.92e-6
RR5 vdd bulk4 ntap1 A=26.815e-12 P=173e-6
RR2 vss bulk2 ptap1 A=8.559e-12 P=57.06e-6
RR4 vss bulk2 ptap1 A=30.288e-12 P=201.92e-6
.ends
