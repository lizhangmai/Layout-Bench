** sch_path: /workspace/source/DIFF_COMPARATOR.sch
.subckt DIFF_COMPARATOR vdd gnd v+ v- clk out- out+ vbias
*.PININFO vdd:B gnd:B v+:I v-:I clk:I out-:O out+:O vbias:I
XM2 net3 v+ net1 well sg13_lv_pmos w=8u l=200n ng=2 m=4 mm_ok=1
XM1 net2 v- net1 well sg13_lv_pmos w=8u l=200n ng=2 m=4 mm_ok=1
XM4 out- net2 vdd well sg13_lv_pmos w=8u l=0.200u ng=2 m=1 mm_ok=1
XM5 out+ net3 vdd well sg13_lv_pmos w=8u l=0.200u ng=2 m=1 mm_ok=1
XM11 gnd net3 out+ sub sg13_lv_nmos w=4.0u l=0.200u ng=2 m=1 mm_ok=1
XM12 gnd net2 out- sub sg13_lv_nmos w=4.0u l=0.200u ng=2 m=1 mm_ok=1
XM6 gnd net2 net3 sub sg13_lv_nmos w=4.0u l=0.200u ng=1 m=1 mm_ok=1
XM10 gnd clk net3 sub sg13_lv_nmos w=4.0u l=0.200u ng=1 m=1 mm_ok=1
XM7 gnd clk net2 sub sg13_lv_nmos w=4.0u l=0.200u ng=1 m=1 mm_ok=1
XM8 gnd net3 net2 sub sg13_lv_nmos w=4.0u l=0.200u ng=1 m=1 mm_ok=1
XM3 gnd gnd gnd sub sg13_lv_nmos w=4.0u l=0.200u ng=1 m=4 mm_ok=1
XM13 net1 clk net4 well sg13_lv_pmos w=18u l=0.3u ng=4 m=1 mm_ok=1
XM9 net4 vbias vdd well sg13_lv_pmos w=18u l=0.3u ng=4 m=1 mm_ok=1
XR1 vdd well ntap1 a=15.376e-12 p=99.2e-6 r=8.553275
XR2 gnd sub ptap1 a=11.376e-12 p=75.84e-6 r=11.23647
.ends
