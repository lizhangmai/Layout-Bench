* Independently authored backend fixture specification, not a benchmark task.
.subckt MOS_SWITCH D G S B
M1 D G S B sg13_lv_nmos w=1u l=0.2u
.ends MOS_SWITCH
