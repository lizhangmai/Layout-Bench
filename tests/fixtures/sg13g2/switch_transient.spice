* Measure delay through the extracted MOS switch, including actual layout C.
.lib cornerMOSlv.lib mos_tt
.include dut.spice
Xdut d g 0 0 MOS_SWITCH
Vdd supply 0 1.2
Rload supply d 10k
Vgate g 0 pulse(0 1.2 1n 10p 10p 100n 200n)
.control
tran 2p 20n
meas tran delay trig v(g) val=0.6 rise=1 targ v(d) val=0.6 fall=1
write transient.raw v(g) v(d)
quit
.endc
.end
